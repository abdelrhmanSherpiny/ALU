ADE simulation setup
Run mode: Single Run, Sweeps and Corners
Tests:
  digital_project:Inverter_TB:1: digital_project/Inverter_TB/schematic, simulator spectre
Global variables:
  Vin = 1.2
